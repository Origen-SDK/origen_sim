simulator lang=spectre

amsAnalysis tran stop=1000m step=10p errpreset=moderate method=trap

amsd {
  //global resolution
  ie vsup=3.3 discipline=logic
  //power domains resolutions
  ie vsup=1.1 vthi= 0.6 cell="pd_main pd_wake"
  ie vsup=1.8 cell="pd_vsys"
  ie vsup=2.5 cell="pd_vbat" discipline=logic
  //ie vsup=3.0 cell="usbxcvr_fsls_tx_pad"
  ie vsup=3.0 cell="usbxcvr_fsls_tx_drv"
  ie vsup=3.0 cell="usbxcvr_fsls_rx_fslsrx"

  // exclude flash ~3.3V signals from default rule for pd_main
  ie vsup=3.3 vthi= 1.6 mode="split" instport="testbench.top.pd_main.fmu0.hm_top.vdd3v testbench.top.pd_main.fmu0.hm_top.array_0.VDIO testbench.top.pd_main.fmu0.hm_top.vpp testbench.top.pd_main.fmu0.hm_top.array_0.VPP testbench.top.pd_main.fmu0.hm_top.tm testbench.top.pd_main.fmu0.hm_top.array_0.TM"

  // PMC
  // ie vsup=1.1 instport=" a_ip_pmc_socvdd_switch_5ma_gf40nvrf.vdd_well_lv a_ip_pmc_socvdd_switch_5ma_gf40nvrf.vss_bulk " discipline=supplies_1p1v

  //ie vsup=3.3 mode="split" instport="testbench.top.iomix.ioring.PTA*"
  //ie vsup=3.3 mode="split" instport="testbench.top.iomix.ioring.PTB*"
  //ie vsup=3.3 mode="split" instport="testbench.top.iomix.ioring.PTC*"
  //ie vsup=3.3 mode="split" instport="testbench.top.iomix.ioring.PTD*"

  // PADRING
  // PTA0/PTA3/PTA4 Pull-Up
  //ie vsup=3.3 mode="split" instport="testbench.top.iomix.ioring.PTA0 testbench.top.iomix.ioring.PTA3 testbench.top.iomix.ioring.PTA4" discipline="wreal_min"
  // PTA1      Pull-Down
  //ie vsup=3.3 mode="split" instport="testbench.top.iomix.ioring.PTA1" discipline="wreal_max"

  //Memories

  connectmap realresolve=avg // default
  connectmap discipline="wreal_voltage" realresolve=avg
  connectmap discipline="wreal_current" realresolve=sum
  connectmap discipline="wreal_max" realresolve=max
  connectmap discipline="wreal_min" realresolve=min

}
